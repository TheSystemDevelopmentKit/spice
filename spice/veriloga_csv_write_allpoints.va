// Verilog-A module to write all voltage values
// to csv-file.
//
// Last modification by Kalle Spoof, kalle.spoof@aalto.fi, 09.04.2021 13:50

`include "constants.vams"
`include "disciplines.vams"

module veriloga_csv_write_allpoints(data);

	parameter string filename = "./default.csv";
	integer file;
	real tran_time;

	input data;
	electrical data;

	analog begin
		@ (initial_step) begin
			file = $fopen(filename, "w");
		end

		tran_time = $abstime;
		$fwrite(file, "%.10g, ", tran_time);
        $fwrite(file, "%g\n", V(data));

		@ (final_step) begin
			$fwrite(file, "\n");
			$fclose(file);
		end
	end

endmodule
