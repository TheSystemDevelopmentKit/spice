// Verilog-A module to write all voltage values
// to csv-file.
//
// Last modification by Okko Järvinen, 08.06.2020 10:41

`include "constants.vams"
`include "disciplines.vams"

module veriloga_csv_write_allpoints_current(pos,neg);

	parameter string filename = "./default.csv";
	integer file;
	real tran_time;

	input pos;
    output neg;
	electrical pos;
	electrical neg;

	analog begin
		@ (initial_step) begin
			file = $fopen(filename, "a");
		end

		tran_time = $abstime;
		$fwrite(file, "%g, ", tran_time);
        $fwrite(file, "%g\n", I(pos,neg));

		@ (final_step) begin
			$fwrite(file, "\n");
			$fclose(file);
		end
	end

endmodule
